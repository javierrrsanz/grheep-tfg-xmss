// Copyright EPFL contributors.
// Licensed under the Apache License, Version 2.0, see LICENSE for details.
// SPDX-License-Identifier: Apache-2.0





{ name: "pad_control",
  clock_primary: "clk_i",
  bus_interfaces: [
    { protocol: "reg_iface", direction: "device" }
  ],
  regwidth: "32",
  registers: [

    { name:     "PAD_MUX_SPI_SLAVE_SCK",
      desc:     "Used to mux pad SPI_SLAVE_SCK",
      resval:   "0x0"
      swaccess: "rw",
      hwaccess: "hro",
      fields: [
        { bits: "0:0", name: "PAD_MUX_SPI_SLAVE_SCK", desc: "Pad Mux SPI_SLAVE_SCK Reg" }
      ]
    }
    { name:     "PAD_MUX_SPI_SLAVE_CS",
      desc:     "Used to mux pad SPI_SLAVE_CS",
      resval:   "0x0"
      swaccess: "rw",
      hwaccess: "hro",
      fields: [
        { bits: "0:0", name: "PAD_MUX_SPI_SLAVE_CS", desc: "Pad Mux SPI_SLAVE_CS Reg" }
      ]
    }
    { name:     "PAD_MUX_SPI_SLAVE_MISO",
      desc:     "Used to mux pad SPI_SLAVE_MISO",
      resval:   "0x0"
      swaccess: "rw",
      hwaccess: "hro",
      fields: [
        { bits: "0:0", name: "PAD_MUX_SPI_SLAVE_MISO", desc: "Pad Mux SPI_SLAVE_MISO Reg" }
      ]
    }
    { name:     "PAD_MUX_SPI_SLAVE_MOSI",
      desc:     "Used to mux pad SPI_SLAVE_MOSI",
      resval:   "0x0"
      swaccess: "rw",
      hwaccess: "hro",
      fields: [
        { bits: "0:0", name: "PAD_MUX_SPI_SLAVE_MOSI", desc: "Pad Mux SPI_SLAVE_MOSI Reg" }
      ]
    }
    { name:     "PAD_MUX_PDM2PCM_PDM",
      desc:     "Used to mux pad PDM2PCM_PDM",
      resval:   "0x0"
      swaccess: "rw",
      hwaccess: "hro",
      fields: [
        { bits: "0:0", name: "PAD_MUX_PDM2PCM_PDM", desc: "Pad Mux PDM2PCM_PDM Reg" }
      ]
    }
    { name:     "PAD_MUX_PDM2PCM_CLK",
      desc:     "Used to mux pad PDM2PCM_CLK",
      resval:   "0x0"
      swaccess: "rw",
      hwaccess: "hro",
      fields: [
        { bits: "0:0", name: "PAD_MUX_PDM2PCM_CLK", desc: "Pad Mux PDM2PCM_CLK Reg" }
      ]
    }
    { name:     "PAD_MUX_I2S_SCK",
      desc:     "Used to mux pad I2S_SCK",
      resval:   "0x0"
      swaccess: "rw",
      hwaccess: "hro",
      fields: [
        { bits: "0:0", name: "PAD_MUX_I2S_SCK", desc: "Pad Mux I2S_SCK Reg" }
      ]
    }
    { name:     "PAD_MUX_I2S_WS",
      desc:     "Used to mux pad I2S_WS",
      resval:   "0x0"
      swaccess: "rw",
      hwaccess: "hro",
      fields: [
        { bits: "0:0", name: "PAD_MUX_I2S_WS", desc: "Pad Mux I2S_WS Reg" }
      ]
    }
    { name:     "PAD_MUX_I2S_SD",
      desc:     "Used to mux pad I2S_SD",
      resval:   "0x0"
      swaccess: "rw",
      hwaccess: "hro",
      fields: [
        { bits: "0:0", name: "PAD_MUX_I2S_SD", desc: "Pad Mux I2S_SD Reg" }
      ]
    }
    { name:     "PAD_MUX_SPI2_CS_0",
      desc:     "Used to mux pad SPI2_CS_0",
      resval:   "0x0"
      swaccess: "rw",
      hwaccess: "hro",
      fields: [
        { bits: "0:0", name: "PAD_MUX_SPI2_CS_0", desc: "Pad Mux SPI2_CS_0 Reg" }
      ]
    }
    { name:     "PAD_MUX_SPI2_CS_1",
      desc:     "Used to mux pad SPI2_CS_1",
      resval:   "0x0"
      swaccess: "rw",
      hwaccess: "hro",
      fields: [
        { bits: "0:0", name: "PAD_MUX_SPI2_CS_1", desc: "Pad Mux SPI2_CS_1 Reg" }
      ]
    }
    { name:     "PAD_MUX_SPI2_SCK",
      desc:     "Used to mux pad SPI2_SCK",
      resval:   "0x0"
      swaccess: "rw",
      hwaccess: "hro",
      fields: [
        { bits: "0:0", name: "PAD_MUX_SPI2_SCK", desc: "Pad Mux SPI2_SCK Reg" }
      ]
    }
    { name:     "PAD_MUX_SPI2_SD_0",
      desc:     "Used to mux pad SPI2_SD_0",
      resval:   "0x0"
      swaccess: "rw",
      hwaccess: "hro",
      fields: [
        { bits: "0:0", name: "PAD_MUX_SPI2_SD_0", desc: "Pad Mux SPI2_SD_0 Reg" }
      ]
    }
    { name:     "PAD_MUX_SPI2_SD_1",
      desc:     "Used to mux pad SPI2_SD_1",
      resval:   "0x0"
      swaccess: "rw",
      hwaccess: "hro",
      fields: [
        { bits: "0:0", name: "PAD_MUX_SPI2_SD_1", desc: "Pad Mux SPI2_SD_1 Reg" }
      ]
    }
    { name:     "PAD_MUX_SPI2_SD_2",
      desc:     "Used to mux pad SPI2_SD_2",
      resval:   "0x0"
      swaccess: "rw",
      hwaccess: "hro",
      fields: [
        { bits: "0:0", name: "PAD_MUX_SPI2_SD_2", desc: "Pad Mux SPI2_SD_2 Reg" }
      ]
    }
    { name:     "PAD_MUX_SPI2_SD_3",
      desc:     "Used to mux pad SPI2_SD_3",
      resval:   "0x0"
      swaccess: "rw",
      hwaccess: "hro",
      fields: [
        { bits: "0:0", name: "PAD_MUX_SPI2_SD_3", desc: "Pad Mux SPI2_SD_3 Reg" }
      ]
    }
    { name:     "PAD_MUX_I2C_SCL",
      desc:     "Used to mux pad I2C_SCL",
      resval:   "0x0"
      swaccess: "rw",
      hwaccess: "hro",
      fields: [
        { bits: "0:0", name: "PAD_MUX_I2C_SCL", desc: "Pad Mux I2C_SCL Reg" }
      ]
    }
    { name:     "PAD_MUX_I2C_SDA",
      desc:     "Used to mux pad I2C_SDA",
      resval:   "0x0"
      swaccess: "rw",
      hwaccess: "hro",
      fields: [
        { bits: "0:0", name: "PAD_MUX_I2C_SDA", desc: "Pad Mux I2C_SDA Reg" }
      ]
    }

    { name:     "PAD_ATTRIBUTE_CLK",
      desc:     "clk Attributes (Pull Up En, Pull Down En, etc. It is technology specific.",
      resval:   "0"
      swaccess: "rw",
      hwaccess: "hro",
      fields: [
        { bits: "7:0", name: "PAD_ATTRIBUTE_CLK", desc: "Pad Attribute CLK Reg" }
      ]
    }
    { name:     "PAD_ATTRIBUTE_RST",
      desc:     "rst Attributes (Pull Up En, Pull Down En, etc. It is technology specific.",
      resval:   "0"
      swaccess: "rw",
      hwaccess: "hro",
      fields: [
        { bits: "7:0", name: "PAD_ATTRIBUTE_RST", desc: "Pad Attribute RST Reg" }
      ]
    }
    { name:     "PAD_ATTRIBUTE_BOOT_SELECT",
      desc:     "boot_select Attributes (Pull Up En, Pull Down En, etc. It is technology specific.",
      resval:   "0"
      swaccess: "rw",
      hwaccess: "hro",
      fields: [
        { bits: "7:0", name: "PAD_ATTRIBUTE_BOOT_SELECT", desc: "Pad Attribute BOOT_SELECT Reg" }
      ]
    }
    { name:     "PAD_ATTRIBUTE_EXECUTE_FROM_FLASH",
      desc:     "execute_from_flash Attributes (Pull Up En, Pull Down En, etc. It is technology specific.",
      resval:   "0"
      swaccess: "rw",
      hwaccess: "hro",
      fields: [
        { bits: "7:0", name: "PAD_ATTRIBUTE_EXECUTE_FROM_FLASH", desc: "Pad Attribute EXECUTE_FROM_FLASH Reg" }
      ]
    }
    { name:     "PAD_ATTRIBUTE_JTAG_TCK",
      desc:     "jtag_tck Attributes (Pull Up En, Pull Down En, etc. It is technology specific.",
      resval:   "0"
      swaccess: "rw",
      hwaccess: "hro",
      fields: [
        { bits: "7:0", name: "PAD_ATTRIBUTE_JTAG_TCK", desc: "Pad Attribute JTAG_TCK Reg" }
      ]
    }
    { name:     "PAD_ATTRIBUTE_JTAG_TMS",
      desc:     "jtag_tms Attributes (Pull Up En, Pull Down En, etc. It is technology specific.",
      resval:   "0"
      swaccess: "rw",
      hwaccess: "hro",
      fields: [
        { bits: "7:0", name: "PAD_ATTRIBUTE_JTAG_TMS", desc: "Pad Attribute JTAG_TMS Reg" }
      ]
    }
    { name:     "PAD_ATTRIBUTE_JTAG_TRST",
      desc:     "jtag_trst Attributes (Pull Up En, Pull Down En, etc. It is technology specific.",
      resval:   "0"
      swaccess: "rw",
      hwaccess: "hro",
      fields: [
        { bits: "7:0", name: "PAD_ATTRIBUTE_JTAG_TRST", desc: "Pad Attribute JTAG_TRST Reg" }
      ]
    }
    { name:     "PAD_ATTRIBUTE_JTAG_TDI",
      desc:     "jtag_tdi Attributes (Pull Up En, Pull Down En, etc. It is technology specific.",
      resval:   "0"
      swaccess: "rw",
      hwaccess: "hro",
      fields: [
        { bits: "7:0", name: "PAD_ATTRIBUTE_JTAG_TDI", desc: "Pad Attribute JTAG_TDI Reg" }
      ]
    }
    { name:     "PAD_ATTRIBUTE_JTAG_TDO",
      desc:     "jtag_tdo Attributes (Pull Up En, Pull Down En, etc. It is technology specific.",
      resval:   "0"
      swaccess: "rw",
      hwaccess: "hro",
      fields: [
        { bits: "7:0", name: "PAD_ATTRIBUTE_JTAG_TDO", desc: "Pad Attribute JTAG_TDO Reg" }
      ]
    }
    { name:     "PAD_ATTRIBUTE_UART_RX",
      desc:     "uart_rx Attributes (Pull Up En, Pull Down En, etc. It is technology specific.",
      resval:   "0"
      swaccess: "rw",
      hwaccess: "hro",
      fields: [
        { bits: "7:0", name: "PAD_ATTRIBUTE_UART_RX", desc: "Pad Attribute UART_RX Reg" }
      ]
    }
    { name:     "PAD_ATTRIBUTE_UART_TX",
      desc:     "uart_tx Attributes (Pull Up En, Pull Down En, etc. It is technology specific.",
      resval:   "0"
      swaccess: "rw",
      hwaccess: "hro",
      fields: [
        { bits: "7:0", name: "PAD_ATTRIBUTE_UART_TX", desc: "Pad Attribute UART_TX Reg" }
      ]
    }
    { name:     "PAD_ATTRIBUTE_EXIT_VALUE",
      desc:     "exit_value Attributes (Pull Up En, Pull Down En, etc. It is technology specific.",
      resval:   "0"
      swaccess: "rw",
      hwaccess: "hro",
      fields: [
        { bits: "7:0", name: "PAD_ATTRIBUTE_EXIT_VALUE", desc: "Pad Attribute EXIT_VALUE Reg" }
      ]
    }
    { name:     "PAD_ATTRIBUTE_EXIT_VALID",
      desc:     "exit_valid Attributes (Pull Up En, Pull Down En, etc. It is technology specific.",
      resval:   "0"
      swaccess: "rw",
      hwaccess: "hro",
      fields: [
        { bits: "7:0", name: "PAD_ATTRIBUTE_EXIT_VALID", desc: "Pad Attribute EXIT_VALID Reg" }
      ]
    }
    { name:     "PAD_ATTRIBUTE_GPIO_0",
      desc:     "gpio_0 Attributes (Pull Up En, Pull Down En, etc. It is technology specific.",
      resval:   "0"
      swaccess: "rw",
      hwaccess: "hro",
      fields: [
        { bits: "7:0", name: "PAD_ATTRIBUTE_GPIO_0", desc: "Pad Attribute GPIO_0 Reg" }
      ]
    }
    { name:     "PAD_ATTRIBUTE_GPIO_1",
      desc:     "gpio_1 Attributes (Pull Up En, Pull Down En, etc. It is technology specific.",
      resval:   "0"
      swaccess: "rw",
      hwaccess: "hro",
      fields: [
        { bits: "7:0", name: "PAD_ATTRIBUTE_GPIO_1", desc: "Pad Attribute GPIO_1 Reg" }
      ]
    }
    { name:     "PAD_ATTRIBUTE_GPIO_2",
      desc:     "gpio_2 Attributes (Pull Up En, Pull Down En, etc. It is technology specific.",
      resval:   "0"
      swaccess: "rw",
      hwaccess: "hro",
      fields: [
        { bits: "7:0", name: "PAD_ATTRIBUTE_GPIO_2", desc: "Pad Attribute GPIO_2 Reg" }
      ]
    }
    { name:     "PAD_ATTRIBUTE_GPIO_3",
      desc:     "gpio_3 Attributes (Pull Up En, Pull Down En, etc. It is technology specific.",
      resval:   "0"
      swaccess: "rw",
      hwaccess: "hro",
      fields: [
        { bits: "7:0", name: "PAD_ATTRIBUTE_GPIO_3", desc: "Pad Attribute GPIO_3 Reg" }
      ]
    }
    { name:     "PAD_ATTRIBUTE_GPIO_4",
      desc:     "gpio_4 Attributes (Pull Up En, Pull Down En, etc. It is technology specific.",
      resval:   "0"
      swaccess: "rw",
      hwaccess: "hro",
      fields: [
        { bits: "7:0", name: "PAD_ATTRIBUTE_GPIO_4", desc: "Pad Attribute GPIO_4 Reg" }
      ]
    }
    { name:     "PAD_ATTRIBUTE_GPIO_5",
      desc:     "gpio_5 Attributes (Pull Up En, Pull Down En, etc. It is technology specific.",
      resval:   "0"
      swaccess: "rw",
      hwaccess: "hro",
      fields: [
        { bits: "7:0", name: "PAD_ATTRIBUTE_GPIO_5", desc: "Pad Attribute GPIO_5 Reg" }
      ]
    }
    { name:     "PAD_ATTRIBUTE_GPIO_6",
      desc:     "gpio_6 Attributes (Pull Up En, Pull Down En, etc. It is technology specific.",
      resval:   "0"
      swaccess: "rw",
      hwaccess: "hro",
      fields: [
        { bits: "7:0", name: "PAD_ATTRIBUTE_GPIO_6", desc: "Pad Attribute GPIO_6 Reg" }
      ]
    }
    { name:     "PAD_ATTRIBUTE_GPIO_7",
      desc:     "gpio_7 Attributes (Pull Up En, Pull Down En, etc. It is technology specific.",
      resval:   "0"
      swaccess: "rw",
      hwaccess: "hro",
      fields: [
        { bits: "7:0", name: "PAD_ATTRIBUTE_GPIO_7", desc: "Pad Attribute GPIO_7 Reg" }
      ]
    }
    { name:     "PAD_ATTRIBUTE_GPIO_8",
      desc:     "gpio_8 Attributes (Pull Up En, Pull Down En, etc. It is technology specific.",
      resval:   "0"
      swaccess: "rw",
      hwaccess: "hro",
      fields: [
        { bits: "7:0", name: "PAD_ATTRIBUTE_GPIO_8", desc: "Pad Attribute GPIO_8 Reg" }
      ]
    }
    { name:     "PAD_ATTRIBUTE_GPIO_9",
      desc:     "gpio_9 Attributes (Pull Up En, Pull Down En, etc. It is technology specific.",
      resval:   "0"
      swaccess: "rw",
      hwaccess: "hro",
      fields: [
        { bits: "7:0", name: "PAD_ATTRIBUTE_GPIO_9", desc: "Pad Attribute GPIO_9 Reg" }
      ]
    }
    { name:     "PAD_ATTRIBUTE_GPIO_10",
      desc:     "gpio_10 Attributes (Pull Up En, Pull Down En, etc. It is technology specific.",
      resval:   "0"
      swaccess: "rw",
      hwaccess: "hro",
      fields: [
        { bits: "7:0", name: "PAD_ATTRIBUTE_GPIO_10", desc: "Pad Attribute GPIO_10 Reg" }
      ]
    }
    { name:     "PAD_ATTRIBUTE_GPIO_11",
      desc:     "gpio_11 Attributes (Pull Up En, Pull Down En, etc. It is technology specific.",
      resval:   "0"
      swaccess: "rw",
      hwaccess: "hro",
      fields: [
        { bits: "7:0", name: "PAD_ATTRIBUTE_GPIO_11", desc: "Pad Attribute GPIO_11 Reg" }
      ]
    }
    { name:     "PAD_ATTRIBUTE_GPIO_12",
      desc:     "gpio_12 Attributes (Pull Up En, Pull Down En, etc. It is technology specific.",
      resval:   "0"
      swaccess: "rw",
      hwaccess: "hro",
      fields: [
        { bits: "7:0", name: "PAD_ATTRIBUTE_GPIO_12", desc: "Pad Attribute GPIO_12 Reg" }
      ]
    }
    { name:     "PAD_ATTRIBUTE_GPIO_13",
      desc:     "gpio_13 Attributes (Pull Up En, Pull Down En, etc. It is technology specific.",
      resval:   "0"
      swaccess: "rw",
      hwaccess: "hro",
      fields: [
        { bits: "7:0", name: "PAD_ATTRIBUTE_GPIO_13", desc: "Pad Attribute GPIO_13 Reg" }
      ]
    }
    { name:     "PAD_ATTRIBUTE_SPI_FLASH_SCK",
      desc:     "spi_flash_sck Attributes (Pull Up En, Pull Down En, etc. It is technology specific.",
      resval:   "0"
      swaccess: "rw",
      hwaccess: "hro",
      fields: [
        { bits: "7:0", name: "PAD_ATTRIBUTE_SPI_FLASH_SCK", desc: "Pad Attribute SPI_FLASH_SCK Reg" }
      ]
    }
    { name:     "PAD_ATTRIBUTE_SPI_FLASH_CS_0",
      desc:     "spi_flash_cs_0 Attributes (Pull Up En, Pull Down En, etc. It is technology specific.",
      resval:   "0"
      swaccess: "rw",
      hwaccess: "hro",
      fields: [
        { bits: "7:0", name: "PAD_ATTRIBUTE_SPI_FLASH_CS_0", desc: "Pad Attribute SPI_FLASH_CS_0 Reg" }
      ]
    }
    { name:     "PAD_ATTRIBUTE_SPI_FLASH_CS_1",
      desc:     "spi_flash_cs_1 Attributes (Pull Up En, Pull Down En, etc. It is technology specific.",
      resval:   "0"
      swaccess: "rw",
      hwaccess: "hro",
      fields: [
        { bits: "7:0", name: "PAD_ATTRIBUTE_SPI_FLASH_CS_1", desc: "Pad Attribute SPI_FLASH_CS_1 Reg" }
      ]
    }
    { name:     "PAD_ATTRIBUTE_SPI_FLASH_SD_0",
      desc:     "spi_flash_sd_0 Attributes (Pull Up En, Pull Down En, etc. It is technology specific.",
      resval:   "0"
      swaccess: "rw",
      hwaccess: "hro",
      fields: [
        { bits: "7:0", name: "PAD_ATTRIBUTE_SPI_FLASH_SD_0", desc: "Pad Attribute SPI_FLASH_SD_0 Reg" }
      ]
    }
    { name:     "PAD_ATTRIBUTE_SPI_FLASH_SD_1",
      desc:     "spi_flash_sd_1 Attributes (Pull Up En, Pull Down En, etc. It is technology specific.",
      resval:   "0"
      swaccess: "rw",
      hwaccess: "hro",
      fields: [
        { bits: "7:0", name: "PAD_ATTRIBUTE_SPI_FLASH_SD_1", desc: "Pad Attribute SPI_FLASH_SD_1 Reg" }
      ]
    }
    { name:     "PAD_ATTRIBUTE_SPI_FLASH_SD_2",
      desc:     "spi_flash_sd_2 Attributes (Pull Up En, Pull Down En, etc. It is technology specific.",
      resval:   "0"
      swaccess: "rw",
      hwaccess: "hro",
      fields: [
        { bits: "7:0", name: "PAD_ATTRIBUTE_SPI_FLASH_SD_2", desc: "Pad Attribute SPI_FLASH_SD_2 Reg" }
      ]
    }
    { name:     "PAD_ATTRIBUTE_SPI_FLASH_SD_3",
      desc:     "spi_flash_sd_3 Attributes (Pull Up En, Pull Down En, etc. It is technology specific.",
      resval:   "0"
      swaccess: "rw",
      hwaccess: "hro",
      fields: [
        { bits: "7:0", name: "PAD_ATTRIBUTE_SPI_FLASH_SD_3", desc: "Pad Attribute SPI_FLASH_SD_3 Reg" }
      ]
    }
    { name:     "PAD_ATTRIBUTE_SPI_SCK",
      desc:     "spi_sck Attributes (Pull Up En, Pull Down En, etc. It is technology specific.",
      resval:   "0"
      swaccess: "rw",
      hwaccess: "hro",
      fields: [
        { bits: "7:0", name: "PAD_ATTRIBUTE_SPI_SCK", desc: "Pad Attribute SPI_SCK Reg" }
      ]
    }
    { name:     "PAD_ATTRIBUTE_SPI_CS_0",
      desc:     "spi_cs_0 Attributes (Pull Up En, Pull Down En, etc. It is technology specific.",
      resval:   "0"
      swaccess: "rw",
      hwaccess: "hro",
      fields: [
        { bits: "7:0", name: "PAD_ATTRIBUTE_SPI_CS_0", desc: "Pad Attribute SPI_CS_0 Reg" }
      ]
    }
    { name:     "PAD_ATTRIBUTE_SPI_CS_1",
      desc:     "spi_cs_1 Attributes (Pull Up En, Pull Down En, etc. It is technology specific.",
      resval:   "0"
      swaccess: "rw",
      hwaccess: "hro",
      fields: [
        { bits: "7:0", name: "PAD_ATTRIBUTE_SPI_CS_1", desc: "Pad Attribute SPI_CS_1 Reg" }
      ]
    }
    { name:     "PAD_ATTRIBUTE_SPI_SD_0",
      desc:     "spi_sd_0 Attributes (Pull Up En, Pull Down En, etc. It is technology specific.",
      resval:   "0"
      swaccess: "rw",
      hwaccess: "hro",
      fields: [
        { bits: "7:0", name: "PAD_ATTRIBUTE_SPI_SD_0", desc: "Pad Attribute SPI_SD_0 Reg" }
      ]
    }
    { name:     "PAD_ATTRIBUTE_SPI_SD_1",
      desc:     "spi_sd_1 Attributes (Pull Up En, Pull Down En, etc. It is technology specific.",
      resval:   "0"
      swaccess: "rw",
      hwaccess: "hro",
      fields: [
        { bits: "7:0", name: "PAD_ATTRIBUTE_SPI_SD_1", desc: "Pad Attribute SPI_SD_1 Reg" }
      ]
    }
    { name:     "PAD_ATTRIBUTE_SPI_SD_2",
      desc:     "spi_sd_2 Attributes (Pull Up En, Pull Down En, etc. It is technology specific.",
      resval:   "0"
      swaccess: "rw",
      hwaccess: "hro",
      fields: [
        { bits: "7:0", name: "PAD_ATTRIBUTE_SPI_SD_2", desc: "Pad Attribute SPI_SD_2 Reg" }
      ]
    }
    { name:     "PAD_ATTRIBUTE_SPI_SD_3",
      desc:     "spi_sd_3 Attributes (Pull Up En, Pull Down En, etc. It is technology specific.",
      resval:   "0"
      swaccess: "rw",
      hwaccess: "hro",
      fields: [
        { bits: "7:0", name: "PAD_ATTRIBUTE_SPI_SD_3", desc: "Pad Attribute SPI_SD_3 Reg" }
      ]
    }
    { name:     "PAD_ATTRIBUTE_SPI_SLAVE_SCK",
      desc:     "spi_slave_sck Attributes (Pull Up En, Pull Down En, etc. It is technology specific.",
      resval:   "0"
      swaccess: "rw",
      hwaccess: "hro",
      fields: [
        { bits: "7:0", name: "PAD_ATTRIBUTE_SPI_SLAVE_SCK", desc: "Pad Attribute SPI_SLAVE_SCK Reg" }
      ]
    }
    { name:     "PAD_ATTRIBUTE_SPI_SLAVE_CS",
      desc:     "spi_slave_cs Attributes (Pull Up En, Pull Down En, etc. It is technology specific.",
      resval:   "0"
      swaccess: "rw",
      hwaccess: "hro",
      fields: [
        { bits: "7:0", name: "PAD_ATTRIBUTE_SPI_SLAVE_CS", desc: "Pad Attribute SPI_SLAVE_CS Reg" }
      ]
    }
    { name:     "PAD_ATTRIBUTE_SPI_SLAVE_MISO",
      desc:     "spi_slave_miso Attributes (Pull Up En, Pull Down En, etc. It is technology specific.",
      resval:   "0"
      swaccess: "rw",
      hwaccess: "hro",
      fields: [
        { bits: "7:0", name: "PAD_ATTRIBUTE_SPI_SLAVE_MISO", desc: "Pad Attribute SPI_SLAVE_MISO Reg" }
      ]
    }
    { name:     "PAD_ATTRIBUTE_SPI_SLAVE_MOSI",
      desc:     "spi_slave_mosi Attributes (Pull Up En, Pull Down En, etc. It is technology specific.",
      resval:   "0"
      swaccess: "rw",
      hwaccess: "hro",
      fields: [
        { bits: "7:0", name: "PAD_ATTRIBUTE_SPI_SLAVE_MOSI", desc: "Pad Attribute SPI_SLAVE_MOSI Reg" }
      ]
    }
    { name:     "PAD_ATTRIBUTE_PDM2PCM_PDM",
      desc:     "pdm2pcm_pdm Attributes (Pull Up En, Pull Down En, etc. It is technology specific.",
      resval:   "0"
      swaccess: "rw",
      hwaccess: "hro",
      fields: [
        { bits: "7:0", name: "PAD_ATTRIBUTE_PDM2PCM_PDM", desc: "Pad Attribute PDM2PCM_PDM Reg" }
      ]
    }
    { name:     "PAD_ATTRIBUTE_PDM2PCM_CLK",
      desc:     "pdm2pcm_clk Attributes (Pull Up En, Pull Down En, etc. It is technology specific.",
      resval:   "0"
      swaccess: "rw",
      hwaccess: "hro",
      fields: [
        { bits: "7:0", name: "PAD_ATTRIBUTE_PDM2PCM_CLK", desc: "Pad Attribute PDM2PCM_CLK Reg" }
      ]
    }
    { name:     "PAD_ATTRIBUTE_I2S_SCK",
      desc:     "i2s_sck Attributes (Pull Up En, Pull Down En, etc. It is technology specific.",
      resval:   "0"
      swaccess: "rw",
      hwaccess: "hro",
      fields: [
        { bits: "7:0", name: "PAD_ATTRIBUTE_I2S_SCK", desc: "Pad Attribute I2S_SCK Reg" }
      ]
    }
    { name:     "PAD_ATTRIBUTE_I2S_WS",
      desc:     "i2s_ws Attributes (Pull Up En, Pull Down En, etc. It is technology specific.",
      resval:   "0"
      swaccess: "rw",
      hwaccess: "hro",
      fields: [
        { bits: "7:0", name: "PAD_ATTRIBUTE_I2S_WS", desc: "Pad Attribute I2S_WS Reg" }
      ]
    }
    { name:     "PAD_ATTRIBUTE_I2S_SD",
      desc:     "i2s_sd Attributes (Pull Up En, Pull Down En, etc. It is technology specific.",
      resval:   "0"
      swaccess: "rw",
      hwaccess: "hro",
      fields: [
        { bits: "7:0", name: "PAD_ATTRIBUTE_I2S_SD", desc: "Pad Attribute I2S_SD Reg" }
      ]
    }
    { name:     "PAD_ATTRIBUTE_SPI2_CS_0",
      desc:     "spi2_cs_0 Attributes (Pull Up En, Pull Down En, etc. It is technology specific.",
      resval:   "0"
      swaccess: "rw",
      hwaccess: "hro",
      fields: [
        { bits: "7:0", name: "PAD_ATTRIBUTE_SPI2_CS_0", desc: "Pad Attribute SPI2_CS_0 Reg" }
      ]
    }
    { name:     "PAD_ATTRIBUTE_SPI2_CS_1",
      desc:     "spi2_cs_1 Attributes (Pull Up En, Pull Down En, etc. It is technology specific.",
      resval:   "0"
      swaccess: "rw",
      hwaccess: "hro",
      fields: [
        { bits: "7:0", name: "PAD_ATTRIBUTE_SPI2_CS_1", desc: "Pad Attribute SPI2_CS_1 Reg" }
      ]
    }
    { name:     "PAD_ATTRIBUTE_SPI2_SCK",
      desc:     "spi2_sck Attributes (Pull Up En, Pull Down En, etc. It is technology specific.",
      resval:   "0"
      swaccess: "rw",
      hwaccess: "hro",
      fields: [
        { bits: "7:0", name: "PAD_ATTRIBUTE_SPI2_SCK", desc: "Pad Attribute SPI2_SCK Reg" }
      ]
    }
    { name:     "PAD_ATTRIBUTE_SPI2_SD_0",
      desc:     "spi2_sd_0 Attributes (Pull Up En, Pull Down En, etc. It is technology specific.",
      resval:   "0"
      swaccess: "rw",
      hwaccess: "hro",
      fields: [
        { bits: "7:0", name: "PAD_ATTRIBUTE_SPI2_SD_0", desc: "Pad Attribute SPI2_SD_0 Reg" }
      ]
    }
    { name:     "PAD_ATTRIBUTE_SPI2_SD_1",
      desc:     "spi2_sd_1 Attributes (Pull Up En, Pull Down En, etc. It is technology specific.",
      resval:   "0"
      swaccess: "rw",
      hwaccess: "hro",
      fields: [
        { bits: "7:0", name: "PAD_ATTRIBUTE_SPI2_SD_1", desc: "Pad Attribute SPI2_SD_1 Reg" }
      ]
    }
    { name:     "PAD_ATTRIBUTE_SPI2_SD_2",
      desc:     "spi2_sd_2 Attributes (Pull Up En, Pull Down En, etc. It is technology specific.",
      resval:   "0"
      swaccess: "rw",
      hwaccess: "hro",
      fields: [
        { bits: "7:0", name: "PAD_ATTRIBUTE_SPI2_SD_2", desc: "Pad Attribute SPI2_SD_2 Reg" }
      ]
    }
    { name:     "PAD_ATTRIBUTE_SPI2_SD_3",
      desc:     "spi2_sd_3 Attributes (Pull Up En, Pull Down En, etc. It is technology specific.",
      resval:   "0"
      swaccess: "rw",
      hwaccess: "hro",
      fields: [
        { bits: "7:0", name: "PAD_ATTRIBUTE_SPI2_SD_3", desc: "Pad Attribute SPI2_SD_3 Reg" }
      ]
    }
    { name:     "PAD_ATTRIBUTE_I2C_SCL",
      desc:     "i2c_scl Attributes (Pull Up En, Pull Down En, etc. It is technology specific.",
      resval:   "0"
      swaccess: "rw",
      hwaccess: "hro",
      fields: [
        { bits: "7:0", name: "PAD_ATTRIBUTE_I2C_SCL", desc: "Pad Attribute I2C_SCL Reg" }
      ]
    }
    { name:     "PAD_ATTRIBUTE_I2C_SDA",
      desc:     "i2c_sda Attributes (Pull Up En, Pull Down En, etc. It is technology specific.",
      resval:   "0"
      swaccess: "rw",
      hwaccess: "hro",
      fields: [
        { bits: "7:0", name: "PAD_ATTRIBUTE_I2C_SDA", desc: "Pad Attribute I2C_SDA Reg" }
      ]
    }
   ]
}
